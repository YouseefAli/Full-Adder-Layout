ADE simulation setup
Run mode: Single Run, Sweeps and Corners
Tests:
  Adder:Full_Adder_TB:1: Adder/Full_Adder_TB/schematic, simulator spectre
Global variables:
  FS = 1G
